* Vérifie la prise en compte de m= sur les instances X (R xhigh_po et nfet)
.lib /foss/pdks/sky130A/libs.tech/ngspice/sky130.lib.spice tt
V1 a 0 1
XR1 a 0 0 sky130_fd_pr__res_xhigh_po_0p35 L=75.24 mult=1 m=1
V2 b 0 1
XR2 b 0 0 sky130_fd_pr__res_xhigh_po_0p35 L=75.24 mult=4 m=4
V3 d1 0 0.1
XM1 d1 g 0 0 sky130_fd_pr__nfet_01v8 L=0.15 W=0.42 nf=1 mult=1 m=1
V4 d4 0 0.1
XM4 d4 g 0 0 sky130_fd_pr__nfet_01v8 L=0.15 W=0.42 nf=1 mult=4 m=4
VG g 0 1.8
.control
op
print i(V1) i(V2) i(V3) i(V4)
.endc
.end
